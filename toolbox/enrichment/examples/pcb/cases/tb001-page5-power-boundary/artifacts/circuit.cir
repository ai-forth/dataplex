.title tb001-page5-power-boundary

* First-pass TB001 page-5/page-4 boundary model: a page-4-derived control signal drives a DMN-class NMOS that pulls down the gate of an FDS6574-class PMOS high-side switch feeding one representative V1P8 UUT branch.
* assumption: This case models one representative switched V1P8 output branch rather than the full page-5 connector and transistor bank.
* assumption: FDS6574 is treated as a PMOS high-side pass element for the branch under test.
* assumption: DMN5L06DMK-AB is treated as an NMOS gate-pull device controlled from the page-4 control boundary.
* assumption: The upstream source is modeled as a 1.8 V rail with small source impedance and local bulk capacitance.
* assumption: The downstream load stands in for one UUT-facing branch such as V1P8-Core/UUT or V1P8-IO/UUT with connector and local capacitance lumped together.
* assumption: J18/J19 are treated as representative outward-facing load boundary candidates, but exact connector-to-rail mapping remains unresolved.
* assumption: This deck is for startup and gating behavior only; it is not yet a validated representation of final device sizing or exact pin mapping.

VMAIN1P8 VIN_SRC 0 DC 1.8
VCTRL EN 0 PULSE(0 3.3 1m 20u 20u 4m 8m)
RSRCPATH VIN_SRC VIN 0.08
CBULKIN VIN 0 10u
RGPULL PGATE VIN 100k
MDRV PGATE EN 0 0 GENERIC_NMOS
MPASS VOUT PGATE VIN VIN GENERIC_PMOS
RLOAD VOUT 0 36
CCLOAD VOUT 0 22u
RBLEED VOUT 0 2k

.model GENERIC_NMOS NMOS(VTO=1.0 KP=40m RS=0.03 RD=0.03)
.model GENERIC_PMOS PMOS(VTO=-0.7 KP=60m RS=0.03 RD=0.03)

.control
set filetype=ascii
tran 20u 12m
print v(VIN) v(EN) v(PGATE) v(VOUT)
wrdata /home/cartheur/ame/aiventure/aiventure-github/ai-forth/dataplex/toolbox/enrichment/examples/pcb/cases/tb001-page5-power-boundary/outputs/sim.dat v(VIN) v(EN) v(PGATE) v(VOUT)
quit
.endc

.end
