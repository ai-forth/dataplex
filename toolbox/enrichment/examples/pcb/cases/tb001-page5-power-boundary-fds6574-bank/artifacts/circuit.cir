.title tb001-page5-power-boundary-fds6574-bank

* Alternate TB001 page-5/page-4 boundary model: the page-4-derived control signal still drives a DMN-class NMOS gate pull-down, but the unresolved FDS6574 family is treated as a stronger composite PMOS pass bank rather than a single pass element.
* assumption: This case keeps the same control-side abstraction as the baseline page-5 case so the main comparison is in the interpretation of the FDS6574 family.
* assumption: FDS6574 is treated here as a stronger composite PMOS pass bank rather than a single PMOS element.
* assumption: DMN5L06DMK-AB is still treated as an NMOS gate-pull device controlled from the page-4 boundary.
* assumption: The upstream source is modeled as a 1.8 V rail with small source impedance and local bulk capacitance.
* assumption: The downstream load still stands in for one representative UUT-facing branch with connector and local capacitance lumped together.
* assumption: This is not a claim of exact device count or exact pin mapping; it is a comparison hypothesis for whether the unresolved FDS6574 family behaves more like a stronger switched bank than a single weak pass element.

VMAIN1P8 VIN_SRC 0 DC 1.8
VCTRL EN 0 PULSE(0 3.3 1m 20u 20u 4m 8m)
RSRCPATH VIN_SRC VIN 0.08
CBULKIN VIN 0 10u
RGPULL PGATE VIN 100k
MDRV PGATE EN 0 0 GENERIC_NMOS
MPASSA VOUT PGATE VIN VIN GENERIC_PMOS
MPASSB VOUT PGATE VIN VIN GENERIC_PMOS
RLOAD VOUT 0 36
CCLOAD VOUT 0 22u
RBLEED VOUT 0 2k

.model GENERIC_NMOS NMOS(VTO=1.0 KP=40m RS=0.03 RD=0.03)
.model GENERIC_PMOS PMOS(VTO=-0.7 KP=60m RS=0.03 RD=0.03)

.control
set filetype=ascii
tran 20u 12m
print v(VIN) v(EN) v(PGATE) v(VOUT)
wrdata /home/cartheur/ame/aiventure/aiventure-github/ai-forth/dataplex/toolbox/enrichment/examples/pcb/cases/tb001-page5-power-boundary-fds6574-bank/outputs/sim.dat v(VIN) v(EN) v(PGATE) v(VOUT)
quit
.endc

.end
